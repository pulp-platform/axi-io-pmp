{
	name: "io_pmp",
    clock_primary: "clk_i",
	reset_primary: "rst_ni",
	bus_interfaces: [{
	    protocol: "reg_iface",
	    direction: "device"
	}],
    regwidth: "64",
	registers: [{
	    multireg: {
            name: "PMP_ADDR",
            desc: "asdf",
            count: "16",
            cname: "PMP",
            swaccess: "rw",
            hwaccess: "hro",
            fields: [{
                bits: "63:0",
                name: "PMP_ADDR",
                desc: "PMP configuration address",
                resval: "0" 
            }]
        }}, {
        multireg: {
            name: "PMP_CFG",
            desc: "asdf",
            count: "16",
            cname: "PMP",
            swaccess: "rw",
            hwaccess: "hro",
            compact: True
            fields: [{
                bits: "2:0",
                name: "PMP_CFG_ACCESS_TYPE",
                resval: "0",
                desc: "Type of interrupt to raise",
                enum: [
                    { value: "0", name: "ACCESS_NONE", desc: "no access" },
                    { value: "1", name: "ACCESS_READ", desc: "read access" },
                    { value: "2", name: "ACCESS_WRITE", desc: "write access" },
                    { value: "4", name: "ACCESS_EXEC", desc: "execute access" }
                ]
            },
            {
                bits: "4:3",
                name: "PMP_CFG_ADDR_MODE",
                resval: "0",
                desc: "Type of interrupt to raise",
                enum: [
                    { value: "0", name: "OFF", desc: "Disabled" },
                    { value: "1", name: "TOR", desc: "TOR mode" },
                    { value: "2", name: "NA4", desc: "NA4 mode" },
                    { value: "3", name: "NAPOT", desc: "NAPOT mode" }
                ]
            },
            {
                bits: "6:5",
                name: "PMP_CFG_RESERVED",
                resval: "0",
                desc: "reservd"
            },
            {
                bits: "7",
                name: "PMP_CFG_LOCKED",
                resval: "0",
                desc: "Type of interrupt to raise",
                enum: [
                    { value: "0", name: "Unlocked", desc: "Unlocked" },
                    { value: "1", name: "Locked", desc: "Locked" }
                ]
            }]
        }
    }]
}